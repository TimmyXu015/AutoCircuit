;; batch job: ECE203 Round 5 Round 5 stage d
load(strcat(or(getShellEnvVar("AC_ROOT") strcat(getShellEnvVar("HOME") "/AutoCircuit")) "/ac.il"))
acBatch('r5StageD)
exit()
