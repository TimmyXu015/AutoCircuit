;; batch job: ECE203 Round 5N-N (b)
load(strcat(or(getShellEnvVar("AC_ROOT") strcat(getShellEnvVar("HOME") "/AutoCircuit")) "/ac.il"))
acBatch('r5nnStageB)
exit()
