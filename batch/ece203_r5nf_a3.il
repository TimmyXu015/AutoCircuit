;; batch job: ECE203 Round 5N-F (a3)
load(strcat(or(getShellEnvVar("AC_ROOT") strcat(getShellEnvVar("HOME") "/AutoCircuit")) "/ac.il"))
acBatch('r5nfStageA3)
exit()
