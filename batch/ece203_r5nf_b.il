;; batch job: ECE203 Round 5N-F (b)
load(strcat(or(getShellEnvVar("AC_ROOT") strcat(getShellEnvVar("HOME") "/AutoCircuit")) "/ac.il"))
acBatch('r5nfStageB)
exit()
