;; batch job: ECE203 Round 5N-N (a)
load(strcat(or(getShellEnvVar("AC_ROOT") strcat(getShellEnvVar("HOME") "/AutoCircuit")) "/ac.il"))
acBatch('r5nnStageA)
exit()
