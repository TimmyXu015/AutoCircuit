;; batch job: ECE203 Round 6C-I (c)
load(strcat(or(getShellEnvVar("AC_ROOT") strcat(getShellEnvVar("HOME") "/AutoCircuit")) "/ac.il"))
acBatch('r6cStageC)
exit()
