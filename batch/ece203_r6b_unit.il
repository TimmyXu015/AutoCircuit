;; batch job: ECE203 Round 6B unit (real MOS TG chopper)
load(strcat(or(getShellEnvVar("AC_ROOT") strcat(getShellEnvVar("HOME") "/AutoCircuit")) "/ac.il"))
acBatch('r6bStageUnit)
exit()
