;; batch job: ECE203 Round 6C-I (a)
load(strcat(or(getShellEnvVar("AC_ROOT") strcat(getShellEnvVar("HOME") "/AutoCircuit")) "/ac.il"))
acBatch('r6cStageA)
exit()
