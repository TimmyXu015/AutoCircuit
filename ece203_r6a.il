;; ECE203 Round 6A micro-PoC: DRL (input/body CM) and fully differential OTA CMFB (output CM) - shared/coordinated control.
;; Task: docs/ECE203_round6a_drl_cmfb_coupled_poc.md. New cells only (ece203_r6a_*); R4/R5 cells are reused read-only
;; (ece203_r4_drl_ota). Jobs: ece203_r6a_a (plant + ideal-controller diagnostics), ece203_r6a_b (real MOS independent
;; DRL + CMFB), ece203_r6a_c (one coordinated candidate), ece203_r6a_d (ideal FD chopper, 1 PSS).
;;
;; One testbench cell ece203_r6a_tb, modes set by variables:
;;   body actuator  : real DRL OTA (rdr 1e6) | ideal source u_body = vref - kb*(wib*e_in + wob*e_out) + aub (rub 1);
;;                    its e_out term is AC-coupled (1e6 F / 1e12: corner ~1e-19 Hz) so the DC point is the plant's
;;   OTA CM actuator: real CMFB block (rcf 1) | AC-only ideal u_ota = ko*(woo*e_out + wio*e_in) + aug through CVG 1e6 F,
;;                    DC of vg still from the real CMFB through RCF 1e12 (so the CMFB loop is open for f >= 1 mHz)
;;   e_in = (inp+inn)/2 - vref (amplifier-side electrode nodes), e_out = (op+on)/2 - vref (OTA outputs)
;;   disturbances: d_body = body current (icm ac / itr 60 Hz sine), d_ota = equal CM current into op and on (izo ac / izst step)
;;   chopper: ideal relays, 2-phase non-overlapping clock (chen 0 -> frozen phase 1 = straight through)

r6Dir = strcat(getShellEnvVar("HOME") "/AutoCircuit_results/ece203_r6a")
r6Cells = list(nil 'ota "ece203_r6a_fd_ota" 'cmfb "ece203_r6a_cmfb" 'tb "ece203_r6a_tb")
r6Vars = list(list("vdd" 1.8) list("vref" 0.9) list("vcas" 1.10) list("ib3" 50e-9) list("ibd" 50e-9)
  list("cc" 50e-12) list("cfb" 0.5e-12) list("rfb" 3.1831e12) list("rs" 2e3) list("re" 1e6) list("ce" 50e-9)
  list("cbody" 200e-12) list("icm" 0.0) list("itr" 0.0) list("adm" 0.0) list("vcmin" 0.0) list("dcc" 0.0) list("pacd" 0.0)
  list("rcm" 10e9) list("ccm" 1e-12) list("rdr" 1e15) list("rub" 1.0) list("rcf" 1e12) list("cvg" 1e6)
  list("kb" 0.0) list("ko" 0.0) list("wib" 1.0) list("wob" 0.0) list("wio" 0.0) list("woo" 1.0) list("aub" 0.0) list("aug" 0.0)
  list("izo" 0.0) list("izdc" 0.0) list("izst" 0.0) list("tzo" 1.0)
  list("cvg" 1e-18)
  list("rff1" 1e15) list("rff2" 1.0) list("rffc" 1e15) list("vos" 0.0) list("chen" 0.0) list("tch" 500e-6))

;; fully differential OTA1 concept: R4 NMOS input pair 10u/8u + local NMOS cascodes on BOTH sides, symmetric PMOS loads
;; driven by VCMFB (no diode side). INP up -> ON down, OP up.
r6OtaDevs = list(
  list("nfetx" "M1" 10e-6 8e-6 "x1" "INP" "tail" "GND")
  list("nfetx" "M2" 10e-6 8e-6 "x2" "INN" "tail" "GND")
  list("nfetx" "MC1" 10e-6 4e-6 "ON" "VCAS" "x1" "GND")
  list("nfetx" "MC2" 10e-6 4e-6 "OP" "VCAS" "x2" "GND")
  list("pfetx" "M3" 2e-6 4e-6 "ON" "VCMFB" "VDD" "VDD")
  list("pfetx" "M4" 2e-6 4e-6 "OP" "VCMFB" "VDD" "VDD")
  list("nfetx" "MT" 8e-6 4e-6 "tail" "IBIAS" "GND" "GND")
  list("nfetx" "MREF" 2e-6 4e-6 "IBIAS" "IBIAS" "GND" "GND"))
;; CMFB: two NMOS differential-difference pairs (OP vs VREF, ON vs VREF), 50 nA tails mirrored from IBIAS, the VREF-side
;; drains summed into diode PMOS MD (1u/4u = half of M3/M4 -> 2x mirror). Output CM up -> less MD current -> VCMFB up ->
;; loads source less -> output CM down (negative). Symmetric DM swing cancels exactly in the summed current.
r6CmfbDevs = list(
  list("nfetx" "MA1" 4e-6 2e-6 "VDD" "OP" "ta" "GND")
  list("nfetx" "MA2" 4e-6 2e-6 "VCMFB" "VREF" "ta" "GND")
  list("nfetx" "MB1" 4e-6 2e-6 "VDD" "ON" "tb" "GND")
  list("nfetx" "MB2" 4e-6 2e-6 "VCMFB" "VREF" "tb" "GND")
  list("nfetx" "MTA" 2e-6 4e-6 "ta" "IBIAS" "GND" "GND")
  list("nfetx" "MTB" 2e-6 4e-6 "tb" "IBIAS" "GND" "GND")
  list("pfetx" "MD" 1e-6 4e-6 "VCMFB" "VCMFB" "VDD" "VDD"))

procedure( r6BuildCell(cell pins devs)
  let( (cv)
    cv = acOpenSch(ece203Lib cell)
    ece203Pins(cv pins)
    ece203Place(cv mapcar(lambda((d) apply('ece203FetSpec d)) devs))
    ece203Finish(cv ece203Lib cell)
    ece203Symbol(ece203Lib cell)
    cell
  )
)
procedure( r6VP(name acm pacp a b)
  list("analogLib" "vpulse" name
       list(list("dc" "0") list("v1" "0") list("v2" "0") list("td" "1") list("tr" "1n") list("tf" "1n")
            list("pw" "1") list("per" "2") list("acm" acm) list("pacm" "pacd") list("pacp" pacp))
       list(list("PLUS" a) list("MINUS" b)))
)
procedure( r6IZ(name net)
  list("analogLib" "ipulse" name
       list(list("i1" "izdc") list("i2" "izdc+izst") list("td" "tzo") list("tr" "1u") list("tf" "1u")
            list("pw" "10") list("per" "20") list("acm" "izo"))
       list(list("PLUS" "gnd!") list("MINUS" net)))
)
procedure( r6Specs()
  list(
    otaV("VREF" "vref" "0" "vref" "gnd!")
    otaV("VCAS" "vcas" "0" "vcas" "gnd!")
    otaV("VDD" "vdd" "0" "vdd" "gnd!")
    otaV("VDDD" "vdd" "0" "vddd" "gnd!")
    otaI("IB" "ib3" "vdd" "ib")
    otaI("IBD" "ibd" "vddd" "ibd")
    ;; body, 60 Hz interference, electrodes (R4 values)
    otaC("CBODY" "cbody" "body" "gnd!")
    list("analogLib" "idc" "IINT" '(("idc" "0") ("acm" "icm")) '(("PLUS" "gnd!") ("MINUS" "body")))
    list("analogLib" "isin" "IINTT" '(("io" "0") ("ia" "itr") ("freq" "60") ("acm" "0")) '(("PLUS" "gnd!") ("MINUS" "body")))
    r6VP("VSP" "adm/2+vcmin" "0" "ep" "body")
    r6VP("VSN" "-adm/2+vcmin" "180" "en" "body")
    otaR("RSP" "rs" "ep" "ep1") otaR("REP" "re" "ep1" "inp") otaC("CEP" "ce" "ep1" "inp")
    otaR("RSN" "rs" "en" "en1") otaR("REN" "re" "en1" "inn") otaC("CEN" "ce" "en1" "inn")
    ;; fully differential capacitive-feedback amplifier, gain Cc/Cfb = 100 (ideal Rfb)
    otaC("CCP" "cc" "inp" "p") otaC("CCX" "cc*dcc" "inp" "p") otaC("CCN" "cc" "inn" "n")
    otaC("CFN" "cfb" "fp" "n") otaR("RFN" "rfb" "fp" "n")
    otaC("CFP" "cfb" "fn" "p") otaR("RFP" "rfb" "fn" "p")
    r4Clk("VCK1" "1.8" "1.8*(1-chen)" "tch/2" "tch/2-1n" "ck1")
    r4Clk("VCK2" "0" "1.8*chen" "tch/2+10n" "tch/2-21n" "ck2")
    chSw("S1P" "p" "ia" "ck1") chSw("S1N" "n" "ibx" "ck1") chSw("S2P" "n" "ia" "ck2") chSw("S2N" "p" "ibx" "ck2")
    list(ece203Lib r6Cells->ota "XA" nil
         '(("INP" "iax") ("INN" "ibx") ("OP" "op") ("ON" "on") ("VDD" "vdd") ("GND" "gnd!") ("IBIAS" "ib")
           ("VCAS" "vcas") ("VCMFB" "vg")))
    otaV("VOS" "vos" "0" "iax" "ia")
    chSw("S3P" "op" "fp" "ck1") chSw("S3N" "on" "fn" "ck1") chSw("S4P" "on" "fp" "ck2") chSw("S4N" "op" "fn" "ck2")
    r6IZ("IZP" "op") r6IZ("IZN" "on")
    ;; CM sensors (ideal, measurement / diagnostic controllers only)
    ldE("EOA" "op" "gnd!" "oh" "gnd!" "0.5") ldE("EOB" "on" "gnd!" "ocm" "oh" "0.5")
    ldE("EIA" "inp" "gnd!" "ih" "gnd!" "0.5") ldE("EIB" "inn" "gnd!" "icm" "ih" "0.5")
    ;; real CMFB (reference input vrc: VREF, optional feed-forward divider from the DRL output)
    list(ece203Lib r6Cells->cmfb "XC" nil
         '(("OP" "op") ("ON" "on") ("VREF" "vrc") ("VCMFB" "vcf") ("VDD" "vdd") ("GND" "gnd!") ("IBIAS" "ib")))
    otaR("RFF2" "rff2" "vref" "vrc") otaR("RFF1" "rff1" "drlr" "vrc") otaR("RFFC" "rffc" "cm" "vrc")
    list("analogLib" "iprobe" "IPRC" nil '(("PLUS" "vcf") ("MINUS" "vcf2")))
    otaR("RCF" "rcf" "vcf2" "vg")
    ;; ideal OTA-CM actuator (AC only): DC of vg always from the real CMFB through RCF; for plant / ideal-controller
    ;; runs RCF = 1e12 and CVG = 1e6 F ties vg (AC) to gac = ko*(woo*e_out + wio*e_in) + aug  (open CMFB loop at >= 1 mHz)
    ldE("EG1" "ocm" "vref" "g1" "gnd!" "ko*woo") ldE("EG2" "icm" "vref" "g2" "g1" "ko*wio")
    otaV("VUG" "0" "aug" "gac" "g2") otaC("CVG" "cvg" "vg" "gac")
    ;; DRL: CM sense + real R4 DRL OTA, or the ideal body actuator
    otaR("RCMP" "rcm" "inp" "cm") otaR("RCMN" "rcm" "inn" "cm")
    otaC("CCMP" "ccm" "inp" "cm") otaC("CCMN" "ccm" "inn" "cm")
    list(ece203Lib "ece203_r4_drl_ota" "XD" nil
         '(("INP" "vref") ("INN" "cm") ("OUT" "drlr") ("VDD" "vddd") ("GND" "gnd!") ("IBIAS" "ibd")))
    otaR("RDRR" "rdr" "drlr" "rl0")
    ldE("EB1" "icm" "vref" "b1" "vref" "-kb*wib") ldE("EOC" "ocm" "vref" "ocx" "vref" "1") otaC("CHP" "1e6" "ocx" "oac") otaR("RHP" "1e12" "oac" "vref")
    ldE("EB2" "oac" "vref" "b2" "b1" "-kb*wob")
    otaV("VUB" "0" "aub" "ub" "b2") otaR("RUB" "rub" "ub" "rl0")
    list("analogLib" "iprobe" "IPRD" nil '(("PLUS" "rl0") ("MINUS" "rl0b")))
    otaR("RSR" "rs" "rl0b" "rl1") otaR("RER" "re" "rl1" "body") otaC("CER" "ce" "rl1" "body"))
)
procedure( r6Build()
  ece203LibInfo()
  r6BuildCell(r6Cells->ota '(("INP" "input") ("INN" "input") ("OP" "output") ("ON" "output") ("VDD" "inputOutput")
                             ("GND" "inputOutput") ("IBIAS" "inputOutput") ("VCAS" "input") ("VCMFB" "input")) r6OtaDevs)
  r6BuildCell(r6Cells->cmfb '(("OP" "input") ("ON" "input") ("VREF" "input") ("VCMFB" "output") ("VDD" "inputOutput")
                              ("GND" "inputOutput") ("IBIAS" "input")) r6CmfbDevs)
  otaTb(r6Cells->tb r6Specs())
)

;; ---------- modes ----------
r6Plant = list(list("rdr" 1e15) list("rub" 1.0) list("rcf" 1e12) list("cvg" 1e6) list("kb" 0.0) list("ko" 0.0))
r6Indep = list(list("rdr" 1e15) list("rub" 1.0) list("rcf" 1e12) list("cvg" 1e6) list("kb" 1000.0) list("ko" 1000.0)
               list("wib" 1.0) list("wob" 0.0) list("wio" 0.0) list("woo" 1.0))
procedure( r6H0(alpha) list(list("rdr" 1e15) list("rub" 1.0) list("rcf" 1e12) list("cvg" 1e6) list("kb" 1000.0) list("ko" 1000.0)
                            list("wib" 1.0) list("wob" alpha) list("wio" 1.0) list("woo" alpha)) )
r6Real = list(list("rdr" 1e6) list("rub" 1e15) list("rcf" 1.0) list("cvg" 1e-18) list("kb" 0.0) list("ko" 0.0))

procedure( r6Set(over) ece203Vars(r6Vars) ece203Vars(over) )
procedure( r6Open(name cols)
  let( (port)
    unless( isDir(r6Dir) createDir(r6Dir) )
    port = outfile(strcat(r6Dir "/" name) "w")
    fprintf(port "%s\n" buildString(mapcar('symbolToString cols) ","))
    port
  )
)
r6Insts = '("XA.M1" "XA.M2" "XA.MC1" "XA.MC2" "XA.M3" "XA.M4" "XA.MT" "XA.MREF"
            "XC.MA1" "XC.MA2" "XC.MB1" "XC.MB2" "XC.MTA" "XC.MTB" "XC.MD" "XD.M1" "XD.M2" "XD.M3" "XD.M4" "XD.MT" "XD.MREF")
r6Freqs = '(0.001 1.0 60.0)
r6DcNodes = '("op" "on" "ocm" "icm" "vg" "vcf" "body" "drlr" "ub" "gac" "p" "n")

;; one AC run, returns DPL of e_in, e_out, vod (complex waves)
procedure( r6AcRun(tag over)
  let( (r)
    ece203Setup(r6Cells->tb strcat("_" tag))
    r4Tight()
    analysis('dc ?saveOppoint t)
    analysis('ac ?start "1m" ?stop "100k" ?dec "20")
    r6Set(over)
    run()
    r = list(nil 'ei ldAc("icm") 'eo ldAc("ocm") 'vod car(errset(ldAc("fp") - ldAc("fn") nil)) 'vd car(errset(ldAc("ep") - ldAc("en") nil)))
    r->ei = and(r->ei car(errset(r->ei - ldAc("vref") nil)))
    r
  )
)
procedure( r6DcInfo(tag)
  let( (s)
    s = "DC"
    foreach(n r6DcNodes s = strcat(s sprintf(nil " %s %s" n r4Num(ldDc(n) "%.5g"))))
    acSay("r6 %s: %s | I_VDD %s I_VDDD %s\n" tag s r4Num(ldIdc("/VDD/PLUS") "%.4g") r4Num(ldIdc("/VDDD/PLUS") "%.4g"))
    ece203OpDump(strcat(r6Dir "/" tag "_dcop.csv") r6Insts)
  )
)
;; write |w| and phase at r6Freqs into a row DPL with prefix
procedure( r6Pts(r pre w)
  foreach(f r6Freqs
    putprop(r ldMag(w f) stringToSymbol(sprintf(nil "%s_m%s" pre if( f < 0.01 "1m" if( f < 2.0 "1" "60")))))
    putprop(r ldPh(w f) stringToSymbol(sprintf(nil "%s_p%s" pre if( f < 0.01 "1m" if( f < 2.0 "1" "60"))))))
)
r6ACols = '(tag mode excitation status reason ei_m1m ei_p1m ei_m1 ei_p1 ei_m60 ei_p60 eo_m1m eo_p1m eo_m1 eo_p1 eo_m60 eo_p60)
procedure( r6ACase(port tag mode exc over)
  let( (r w ok)
    r = list(nil 'tag tag 'mode mode 'excitation exc 'status "ok")
    ok = errset(
      progn(
        w = r6AcRun(tag over)
        r6Pts(r "ei" w->ei) r6Pts(r "eo" w->eo)
        ldWriteCurves(strcat(r6Dir "/" tag "_ac.csv") list(list("ei" w->ei) list("eo" w->eo) list("vod" w->vod)))
        t)
      t)
    unless( ok r->status = "failed" r->reason = sprintf(nil "%L" errset.errset))
    acSay("r6A %s [%s, %s]: %s %s | e_in 1m/1/60 %s %s %s | e_out %s %s %s\n" tag mode exc r->status or(r->reason "")
          r4Num(r->ei_m1m "%.4g") r4Num(r->ei_m1 "%.4g") r4Num(r->ei_m60 "%.4g")
          r4Num(r->eo_m1m "%.4g") r4Num(r->eo_m1 "%.4g") r4Num(r->eo_m60 "%.4g"))
    r4Row(port r6ACols r)
    r
  )
)
;; ---------- Stage A: 2x2 plant + disturbance responses (ideal actuators), ideal independent vs H0 single controller ----------
procedure( r6StageA()
  let( (port)
    r6Build()
    unless( isDir(r6Dir) createDir(r6Dir) )
    ;; operating point and DM polarity in plant mode
    r6AcRun("A0_op_dm" append(r6Plant list(list("adm" 1.0))))
    r6DcInfo("A0_op_dm")
    acSay("r6A A0: DM |vod/vd| @10/100 Hz %s %s phase@100 %s\n"
          r4Num(ldMag(ldDiv(ldAc("fp") - ldAc("fn") ldAc("ep") - ldAc("en")) 10.0) "%.4g")
          r4Num(ldMag(ldDiv(ldAc("fp") - ldAc("fn") ldAc("ep") - ldAc("en")) 100.0) "%.4g")
          r4Num(ldPh(ldDiv(ldAc("fp") - ldAc("fn") ldAc("ep") - ldAc("en")) 100.0) "%.1f"))
    port = r6Open("r6a_stageA.csv" r6ACols)
    r6ACase(port "A1_P_ubody" "plant (ideal actuators, open)" "u_body 1 V" append(r6Plant list(list("aub" 1.0))))
    r6ACase(port "A1_P_uota" "plant (ideal actuators, open)" "u_OTAcm 1 V" append(r6Plant list(list("aug" 1.0))))
    r6ACase(port "A1_D_body" "plant (ideal actuators, open)" "d_body 0.1 uA" append(r6Plant list(list("icm" 1e-7))))
    r6ACase(port "A1_D_ota" "plant (ideal actuators, open)" "d_ota 1 nA/side" append(r6Plant list(list("izo" 1e-9))))
    r6ACase(port "A2_indep_dbody" "ideal independent K=1000/1000" "d_body 0.1 uA" append(r6Indep list(list("icm" 1e-7))))
    r6ACase(port "A2_indep_dota" "ideal independent K=1000/1000" "d_ota 1 nA/side" append(r6Indep list(list("izo" 1e-9))))
    r6ACase(port "A3_H0_dbody" "ideal H0 single error e_in+e_out, K=1000 both" "d_body 0.1 uA" append(r6H0(1.0) list(list("icm" 1e-7))))
    r6ACase(port "A3_H0_dota" "ideal H0 single error e_in+e_out, K=1000 both" "d_ota 1 nA/side" append(r6H0(1.0) list(list("izo" 1e-9))))
    close(port)
    t
  )
)

;; ---------- Stage B: real MOS FD OTA + real CMFB + real R4 DRL OTA (independent loops) ----------
r6GCols = '(tag mode status reason Hdm10 Hdm100 ph100 Acm60 CMRR60_dB ei_cm60 eo_cm60 I_VDD I_VDDD op on vg vcf body drlr
            cmfb_ugf cmfb_pm cmfb_lgdc cmfb_ph0 drl_ugf drl_pm drl_lg60 drl_lgdc drl_ph0
            tr_ei_pp tr_eo_pp60 tr_vod_pp60 tr_eo_step tr_ei_step tr_eo_t90 tr_eo_min tr_eo_max)
procedure( r6Gains(r tag over)
  let( (w h)
    w = r6AcRun(strcat(tag "_dm") append(over list(list("adm" 1.0))))
    r6DcInfo(strcat(tag "_dm"))
    r->I_VDD = ldIdc("/VDD/PLUS") r->I_VDDD = ldIdc("/VDDD/PLUS")
    foreach(n '("op" "on" "vg" "vcf" "body" "drlr") putprop(r ldDc(n) stringToSymbol(n)))
    h = ldDiv(w->vod w->vd)
    r->Hdm10 = ldMag(h 10.0) r->Hdm100 = ldMag(h 100.0) r->ph100 = ldPh(h 100.0)
    ldWriteCurves(strcat(r6Dir "/" tag "_dm_ac.csv") list(list("Hdm" h) list("ei" w->ei) list("eo" w->eo)))
    w = r6AcRun(strcat(tag "_cm") append(over list(list("vcmin" 1.0))))
    r->Acm60 = ldMag(w->vod 60.0)
    r->CMRR60_dB = and(r->Acm60 r->Hdm100 ece203Db(ldMag(h 60.0) / r->Acm60))
    r->ei_cm60 = ldMag(w->ei 60.0) r->eo_cm60 = ldMag(w->eo 60.0)
    ldWriteCurves(strcat(r6Dir "/" tag "_cm_ac.csv") list(list("vod" w->vod) list("ei" w->ei) list("eo" w->eo)))
  )
)
procedure( r6Stb(r tag over)
  let( (s)
    foreach(lp '(("cmfb" "/IPRC") ("drl" "/IPRD"))
      ece203Setup(r6Cells->tb strcat("_" tag "_stb" car(lp)))
      r4Tight()
      analysis('stb ?start "1m" ?stop "100M" ?dec "20" ?probe cadr(lp))
      r6Set(over)
      run()
      s = otaStb()
      putprop(r nth(0 s) stringToSymbol(strcat(car(lp) "_ugf"))) putprop(r nth(1 s) stringToSymbol(strcat(car(lp) "_pm")))
      putprop(r nth(4 s) stringToSymbol(strcat(car(lp) "_ph0")))
      putprop(r and(nth(3 s) ldMag(nth(3 s) 1e-3)) stringToSymbol(strcat(car(lp) "_lgdc")))
      when( car(lp) == "drl" r->drl_lg60 = and(nth(3 s) ldMag(nth(3 s) 60.0)))
      ldWriteCurves(strcat(r6Dir "/" tag "_stb_" car(lp) ".csv") list(list("LG" nth(3 s)))))
  )
)
;; tran: 0.1 uA 60 Hz body current all the time + 1 nA/side OTA CM current step at 60 ms
procedure( r6Tran(r tag over)
  let( (ip in op on eo ei vod a b fin t90)
    ece203Setup(r6Cells->tb strcat("_" tag "_tran"))
    r4Tight()
    analysis('tran ?stop "120m" ?maxstep "20u")
    r6Set(append(over list(list("itr" 1e-7) list("izst" 1e-9) list("tzo" 60e-3))))
    run()
    ip = v("/inp" ?result "tran") in = v("/inn" ?result "tran") op = v("/op" ?result "tran") on = v("/on" ?result "tran")
    ei = (ip + in) / 2.0 - 0.9 eo = (op + on) / 2.0 - 0.9 vod = v("/fp" ?result "tran") - v("/fn" ?result "tran")
    r->tr_ei_pp = chPp(ei 40e-3 60e-3) r->tr_eo_pp60 = chPp(eo 40e-3 60e-3) r->tr_vod_pp60 = chPp(vod 40e-3 60e-3)
    a = chAvg(eo 43.333e-3 60e-3) b = chAvg(eo 103.333e-3 120e-3)
    r->tr_eo_step = b - a
    r->tr_ei_step = chAvg(ei 103.333e-3 120e-3) - chAvg(ei 43.333e-3 60e-3)
    r->tr_eo_min = ymin(clip(eo 60e-3 120e-3)) r->tr_eo_max = ymax(clip(eo 60e-3 120e-3))
    fin = a + 0.9 * (b - a)
    t90 = car(errset(cross(clip(eo 60e-3 120e-3) fin 1 if( b > a "rising" "falling")) nil))
    r->tr_eo_t90 = and(numberp(t90) t90 - 60e-3)
    spsWriteWaves(strcat(r6Dir "/" tag "_tran.csv") "t_s,e_in_V,e_out_V,vod_V" list(ei eo vod))
  )
)
procedure( r6RealCase(port tag mode over)
  let( (r ok)
    r = list(nil 'tag tag 'mode mode 'status "ok")
    ok = errset( progn( r6Gains(r tag over) r6Stb(r tag over) r6Tran(r tag over) t) t)
    unless( ok r->status = "failed" r->reason = sprintf(nil "%L" errset.errset))
    acSay("r6G %s [%s]: %s %s | Hdm 10/100 %s %s ph %s | CMRR60 %s dB (ei %s eo %s) | I %s %s | op %s on %s vg %s vcf %s body %s drlr %s\n"
          tag mode r->status or(r->reason "") r4Num(r->Hdm10 "%.4g") r4Num(r->Hdm100 "%.4g") r4Num(r->ph100 "%.1f")
          r4Num(r->CMRR60_dB "%.2f") r4Num(r->ei_cm60 "%.4g") r4Num(r->eo_cm60 "%.4g")
          r4Num(r->I_VDD "%.4g") r4Num(r->I_VDDD "%.4g") r4Num(r->op "%.5g") r4Num(r->on "%.5g") r4Num(r->vg "%.5g")
          r4Num(r->vcf "%.5g") r4Num(r->body "%.5g") r4Num(r->drlr "%.5g"))
    acSay("r6G %s: CMFB stb UGF %s PM %s LGdc %s ph0 %s | DRL stb UGF %s PM %s LG60 %s LGdc %s ph0 %s\n" tag
          r4Num(r->cmfb_ugf "%.4g") r4Num(r->cmfb_pm "%.1f") r4Num(r->cmfb_lgdc "%.4g") r4Num(r->cmfb_ph0 "%.1f")
          r4Num(r->drl_ugf "%.4g") r4Num(r->drl_pm "%.1f") r4Num(r->drl_lg60 "%.4g") r4Num(r->drl_lgdc "%.4g") r4Num(r->drl_ph0 "%.1f"))
    acSay("r6G %s tran: e_in pp %s e_out pp %s vod pp %s (60 Hz window) | d_ota step: e_out %s e_in %s t90 %s s, e_out range %s..%s\n" tag
          r4Num(r->tr_ei_pp "%.4g") r4Num(r->tr_eo_pp60 "%.4g") r4Num(r->tr_vod_pp60 "%.4g") r4Num(r->tr_eo_step "%.4g")
          r4Num(r->tr_ei_step "%.4g") r4Num(r->tr_eo_t90 "%.4g") r4Num(r->tr_eo_min "%.4g") r4Num(r->tr_eo_max "%.4g"))
    r4Row(port r6GCols r)
    r
  )
)
procedure( r6StageB()
  let( (port portD)
    r6Build()
    port = r6Open("r6a_stageB.csv" r6GCols)
    r6RealCase(port "B1_real_indep" "real FD OTA + real CMFB + real DRL OTA, independent" append(r6Real list(list("dcc" 0.01))))
    close(port)
    portD = r6Open("r6a_stageB_dist.csv" r6ACols)
    r6ACase(portD "B1_real_dbody" "real independent" "d_body 0.1 uA" append(r6Real list(list("icm" 1e-7))))
    r6ACase(portD "B1_real_dota" "real independent" "d_ota 1 nA/side" append(r6Real list(list("izo" 1e-9))))
    close(portD)
    t
  )
)

;; ---------- Stage C: ONE coordinated candidate (H2): DRL output fed forward into the CMFB reference ----------
;; Stage A/B show the coupling is one-directional: body CM -> (Cc) -> OTA input CM -> output CM; OTA-internal CM barely
;; reaches the body. H2 keeps both local loops (DRL on e_in, CMFB on e_out) and adds a passive divider drlr -> vrc
;; (rff1 / rff2) so the CMFB reference pre-cancels the body-induced output-CM error. kff is taken from the measured
;; complex ratio -e_out/drlr at 60 Hz in the same real circuit (one probe run); only a positive, ~real kff is
;; implementable with a divider. kff = 0 is the Stage-B baseline (same MOS).
procedure( r6StageC()
  let( (port portD w k kre kim kff rff over src)
    r6Build()
    w = r6AcRun("C0_probe_dbody" append(r6Real list(list("icm" 1e-7))))
    foreach(n '("drlr" "cm")
      k = car(errset(value(-1.0 * w->eo / (ldAc(n) - ldAc("vref")) 60.0) nil))
      kre = and(k car(errset(real(k) nil))) kim = and(k car(errset(imag(k) nil)))
      acSay("r6C probe: source %s |v|@60 %s |e_out|@60 %s -> k = -e_out/v = %s + j%s\n" n r4Num(ldMag(ldAc(n) 60.0) "%.4g")
            r4Num(ldMag(w->eo 60.0) "%.4g") r4Num(kre "%.4g") r4Num(kim "%.4g"))
      when( and(!src numberp(kre) kre > 0.0 abs(kim) < 0.5 * kre) src = n kff = kre))
    port = r6Open("r6a_stageC.csv" r6GCols)
    if( src
      progn(
        ;; divider src -> vrc (rff) and vrc -> VREF (rff2 = 1e10)
        rff = 1e10 * (1.0 / kff - 1.0)
        acSay("r6C: feed-forward source %s kff %g -> R(src-vrc) %g, R(vrc-VREF) 1e10\n" src kff rff)
        over = append(r6Real list(list("dcc" 0.01) list("rff2" 1e10) list(if( src == "cm" "rffc" "rff1") rff)))
        r6RealCase(port "C1_H2_ff" sprintf(nil "H2: CMFB ref feed-forward from %s kff %.4g" src kff) over)
        portD = r6Open("r6a_stageC_dist.csv" r6ACols)
        r6ACase(portD "C1_H2_dbody" "H2 feed-forward" "d_body 0.1 uA" append(over list(list("icm" 1e-7) list("dcc" 0.0))))
        r6ACase(portD "C1_H2_dota" "H2 feed-forward" "d_ota 1 nA/side" append(over list(list("izo" 1e-9) list("dcc" 0.0))))
        close(portD))
      acSay("r6C: kff not implementable with a passive divider from drlr or cm -> C BLOCKED\n"))
    close(port)
    t
  )
)

;; ---------- Stage D: ideal fully differential chopper (input + output commutators around the same FD OTA), 1 PSS ----------
r6DCols = '(tag status reason fch pac10 pac100 pac100_ph pac_cm100 static_H100 ratio vod_avg vod_pp ocm_avg ocm_pp
            op_min op_max on_min on_max icm_pp vg_min vg_max)
procedure( r6StageD()
  let( (port r ok res w vd h hc m)
    r6Build()
    port = r6Open("r6a_stageD.csv" r6DCols)
    r = list(nil 'tag "D1_fdchop_2k" 'status "ok" 'fch 2000.0 'static_H100 94.56)
    ok = errset(
      progn(
        ece203Setup(r6Cells->tb "_D1_fdchop_2k")
        r4Tight()
        analysis('pss ?fund "2k" ?harms "30" ?errpreset "moderate")
        analysis('pac ?sweeptype "relative" ?relharmnum "0" ?start "1" ?stop "250" ?dec "20" ?maxsideband "3")
        r6Set(append(r6Real list(list("chen" 1.0) list("tch" 500e-6) list("pacd" 0.5))))
        run()
        res = strcat(getShellEnvVar("HOME") "/simulation/" r6Cells->tb "/spectre/schematic_D1_fdchop_2k")
        openResults(strcat(res "/psf")) selectResult('pss_td)
        w = list(nil 'op v("/op") 'on v("/on") 'fp v("/fp") 'fn v("/fn") 'ocm v("/ocm") 'icm v("/icm") 'vg v("/vg"))
        m = w->fp - w->fn
        r->vod_avg = average(m) r->vod_pp = ymax(m) - ymin(m)
        r->ocm_avg = average(w->ocm) r->ocm_pp = ymax(w->ocm) - ymin(w->ocm)
        r->op_min = ymin(w->op) r->op_max = ymax(w->op) r->on_min = ymin(w->on) r->on_max = ymax(w->on)
        r->icm_pp = ymax(w->icm) - ymin(w->icm) r->vg_min = ymin(w->vg) r->vg_max = ymax(w->vg)
        spsWriteWaves(strcat(r6Dir "/D1_fdchop_2k_pss_td.csv") "t_s,op_V,on_V,fp_V,fn_V,ocm_V,vg_V"
                      list(w->op w->on w->fp w->fn w->ocm w->vg))
        vd = harmonic(v("/ep" ?result "pac") - v("/en" ?result "pac") 0)
        h = harmonic(v("/fp" ?result "pac") - v("/fn" ?result "pac") 0) / vd
        hc = harmonic(v("/ocm" ?result "pac") 0) / vd
        r->pac10 = ldMag(h 10.0) r->pac100 = ldMag(h 100.0) r->pac100_ph = ldPh(h 100.0) r->pac_cm100 = ldMag(hc 100.0)
        r->ratio = and(numberp(r->pac100) r->pac100 / 94.56)
        ldWriteCurves(strcat(r6Dir "/D1_fdchop_2k_pac.csv") list(list("Hdm" h) list("Hcm_from_dm" hc)))
        t)
      t)
    unless( ok r->status = "failed" r->reason = sprintf(nil "%L" errset.errset))
    acSay("r6D %s: %s %s | PAC |Hdm| 10/100 %s %s ph %s (static 94.56, ratio %s) | ocm from DM %s | PSS vod avg %s pp %s | ocm avg %s pp %s | op %s..%s on %s..%s | icm pp %s | vg %s..%s\n"
          r->tag r->status or(r->reason "") r4Num(r->pac10 "%.4g") r4Num(r->pac100 "%.4g") r4Num(r->pac100_ph "%.1f")
          r4Num(r->ratio "%.4f") r4Num(r->pac_cm100 "%.3g") r4Num(r->vod_avg "%.4g") r4Num(r->vod_pp "%.4g")
          r4Num(r->ocm_avg "%.5g") r4Num(r->ocm_pp "%.4g") r4Num(r->op_min "%.4g") r4Num(r->op_max "%.4g")
          r4Num(r->on_min "%.4g") r4Num(r->on_max "%.4g") r4Num(r->icm_pp "%.3g") r4Num(r->vg_min "%.5g") r4Num(r->vg_max "%.5g"))
    r4Row(port r6DCols r)
    close(port)
    t
  )
)

;; D2 (diagnostic): 1 mV input offset (ideal VOS after the input commutator), static vs 2 kHz chopped, short tran
procedure( r6StageD2()
  let( (port r ok op on fp fn ocm vod)
    r6Build()
    port = r6Open("r6a_stageD2_offset.csv" '(tag chen status vod_avg vod_pp ocm_avg ocm_pp op_min op_max on_min on_max))
    foreach(ch '(0.0 1.0)
      r = list(nil 'tag sprintf(nil "D2_vos1m_chen%d" round(ch)) 'chen ch 'status "ok")
      ok = errset(
        progn(
          ece203Setup(r6Cells->tb strcat("_" r->tag))
          r4Tight()
          analysis('tran ?stop "20m" ?maxstep "2u")
          r6Set(append(r6Real list(list("chen" ch) list("tch" 500e-6) list("vos" 1e-3))))
          run()
          op = v("/op" ?result "tran") on = v("/on" ?result "tran") fp = v("/fp" ?result "tran") fn = v("/fn" ?result "tran")
          ocm = (op + on) / 2.0 vod = fp - fn
          r->vod_avg = chAvg(vod 18e-3 20e-3) r->vod_pp = chPp(vod 18e-3 20e-3)
          r->ocm_avg = chAvg(ocm 18e-3 20e-3) r->ocm_pp = chPp(ocm 18e-3 20e-3)
          r->op_min = ymin(clip(op 18e-3 20e-3)) r->op_max = ymax(clip(op 18e-3 20e-3))
          r->on_min = ymin(clip(on 18e-3 20e-3)) r->on_max = ymax(clip(on 18e-3 20e-3))
          spsWriteWaves(strcat(r6Dir "/" r->tag "_tran.csv") "t_s,op_V,on_V,fp_V,fn_V" list(op on fp fn))
          t)
        t)
      unless( ok r->status = "failed")
      acSay("r6D2 %s: %s | vod avg %s pp %s | ocm avg %s pp %s | op %s..%s on %s..%s\n" r->tag r->status
            r4Num(r->vod_avg "%.4g") r4Num(r->vod_pp "%.4g") r4Num(r->ocm_avg "%.5g") r4Num(r->ocm_pp "%.4g")
            r4Num(r->op_min "%.4g") r4Num(r->op_max "%.4g") r4Num(r->on_min "%.4g") r4Num(r->on_max "%.4g"))
      r4Row(port '(tag chen status vod_avg vod_pp ocm_avg ocm_pp op_min op_max on_min on_max) r))
    close(port)
    t
  )
)

;; ---------- ADE L state (GUI job ece203_r6a_ade): real independent DRL + CMFB configuration of ece203_r6a_tb ----------
procedure( r6Ade()
  let( (sess all)
    hw1NoLicensePrompts()
    when( hiGraphicMode() acAutoOkStart() )
    unless( hiGraphicMode() error("r6Ade needs the GUI (run.sh ece203_r6a_ade)\n") )
    sess = acAdeStart(ece203Lib r6Cells->tb)
    unless( sess error("No ADE session for %s\n" r6Cells->tb) )
    acAdeModels(sess "tt")
    acAdeSaveCurrents(sess)
    foreach(o '((gmin "1e-18") (iabstol "1e-18") (reltol "1e-6")) car(errset(asiSetSimOptionVal(sess car(o) cadr(o)) nil)))
    acAdeAnalysis(sess 'dc list(list('saveOppoint t)))
    acAdeAnalysis(sess 'ac list(list('start "1m") list('stop "100k") list('dec "20"))
      list(list('sweep "freq") list('rangeType "start") list('incrType "log") list('stepTypeLog "decade")))
    acAdeAnalysis(sess 'stb list(list('start "1m") list('stop "100M") list('dec "20") list('probe "/IPRC"))
      list(list('sweep "freq") list('rangeType "start") list('incrType "log") list('stepTypeLog "decade")))
    acAdeOutput(acAdeSev "Hdm_dB" "db20((VF(\"/fp\") - VF(\"/fn\")) / (VF(\"/ep\") - VF(\"/en\")))")
    acAdeOutput(acAdeSev "e_out" "(VF(\"/op\") + VF(\"/on\")) / 2")
    acAdeOutput(acAdeSev "e_in" "(VF(\"/inp\") + VF(\"/inn\")) / 2")
    acAdeOutput(acAdeSev "cmfbLoopGain" "getData(\"loopGain\" ?result \"stb\")")
    all = r6Vars
    foreach(o append(r6Real list(list("adm" 1.0) list("dcc" 0.01))) all = cons(o setof(x all car(x) != car(o))))
    acAdeVars(sess mapcar(lambda((x) list(car(x) sprintf(nil "%g" float(cadr(x))))) all))
    acAdeSave(sess ece203Lib r6Cells->tb "r6a_B1_real_indep")
    t
  )
)
