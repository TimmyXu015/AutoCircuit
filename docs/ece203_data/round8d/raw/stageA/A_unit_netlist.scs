// Design: Project/ece203_r8d_tg_tb
simulator lang=spectre
global 0
parameters tch=0.0005 chen=0.0 pb=0.0 pa=1.0 rl=1e+15 iro=1e-07 cl=1e-12 fin=100.0 vd=0.0 vdc=0.0 vcm=0.9 vdd=1.8 phires=0 p5vonly=0
include "design.scs"
include "wafer.scs"
include "allModels.scs" section=tt

// Project/ece203_r8d_ideal_tg/schematic
subckt ece203_r8d_ideal_tg CKA CKAB CKB CKBB GND INN INP OUTN OUTP VDD
    SB2 (INN OUTP CKB GND) relay vt1=800.0m vt2=1.0 ropen=100e+18 rclosed=1.68K
    SB1 (INP OUTN CKB GND) relay vt1=800.0m vt2=1.0 ropen=100e+18 rclosed=1.68K
    SA2 (INN OUTN CKA GND) relay vt1=800.0m vt2=1.0 ropen=100e+18 rclosed=1.68K
    SA1 (INP OUTP CKA GND) relay vt1=800.0m vt2=1.0 ropen=100e+18 rclosed=1.68K
ends ece203_r8d_ideal_tg

// Project/ece203_r8d_tg_tb/schematic
VCMO (vcmo 0) vsource dc=vcm mag=0 type=dc
VDD (vdd 0) vsource dc=vdd mag=0 type=dc
VN (inn 0) vsource dc=vcm-vdc/2 mag=0 type=sine sinedc=vcm-vdc/2 ampl=vd/2 sinephase=180 freq=fin
VP (inp 0) vsource dc=vcm+vdc/2 mag=0 type=sine sinedc=vcm+vdc/2 ampl=vd/2 freq=fin
XT (cka ckab ckb ckbb 0 inn inp outn outp vdd) ece203_r8d_ideal_tg
CLN (outn 0) capacitor c=cl
CLP (outp 0) capacitor c=cl
IRO (outp 0) isource dc=iro mag=0 type=dc
RLN (outn vcmo) resistor r=rl
RLP (outp vcmo) resistor r=rl
VCKBB (ckbb 0) vsource mag=0 type=pulse pacmag=0 pacphase=0 val0=1.8-1.8*pb val1=1.8-1.8*(pb+chen) period=tch delay=tch/2+10n rise=1n fall=1n width=tch/2-21n
VCKB (ckb 0) vsource mag=0 type=pulse pacmag=0 pacphase=0 val0=1.8*pb val1=1.8*(pb+chen) period=tch delay=tch/2+10n rise=1n fall=1n width=tch/2-21n
VCKAB (ckab 0) vsource mag=0 type=pulse pacmag=0 pacphase=0 val0=1.8-1.8*pa val1=1.8-1.8*pa*(1-chen) period=tch delay=tch/2 rise=1n fall=1n width=tch/2-1n
VCKA (cka 0) vsource mag=0 type=pulse pacmag=0 pacphase=0 val0=1.8*pa val1=1.8*pa*(1-chen) period=tch delay=tch/2 rise=1n fall=1n width=tch/2-1n
simulatorOptions options temp=27 tnom=25 gmin=1e-18
dcOp dc
