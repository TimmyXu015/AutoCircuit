// Design: Project/ece203_ss_pr_iv_tb
simulator lang=spectre
global 0
parameters prl=2e-06 prw=4e-06 vd=0.1 vcm=0.9 p5vonly=0 phires=0
include "design.scs"
include "wafer.scs"
include "allModels.scs" section=tt

// Project/ece203_ss_pr_cell/schematic
subckt ece203_ss_pr_cell A B
    MP (B B A B) pfet33 l=prl w=prw nf=1 m=1 gcon=1 rf=0 dtemp=0
ends ece203_ss_pr_cell

// Project/ece203_ss_pr_iv_tb/schematic
VA (a 0) vsource dc=vcm+vd mag=1 type=dc
VB (b 0) vsource dc=vcm mag=0 type=dc
XP (a b) ece203_ss_pr_cell
simulatorOptions options reltol=1e-6 iabstol=1e-18 temp=27 tnom=25 gmin=1e-18
ac ac start=1m stop=10m dec=1
dcOp dc
save VB:p VA:p
