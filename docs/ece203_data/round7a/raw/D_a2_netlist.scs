// Design: Project/ece203_r7a_det_tb_a2
simulator lang=spectre
global 0
parameters vd=0.0 vcm=0.92 ib3=5e-08 vref=0.9 vdd=1.8 phires=0 p5vonly=0
include "design.scs"
include "wafer.scs"
include "allModels.scs" section=tt

// Project/ece203_r7a_cmfb_a2/schematic
subckt ece203_r7a_cmfb_a2 GND IBIAS ON OP VCMFB VDD VREF
    MTB (tb IBIAS GND GND) nfet l=8u w=10u nf=1 m=1 gcon=1 rf=0 stis=2 dtemp=0 gns=0
    MTA (ta IBIAS GND GND) nfet l=8u w=10u nf=1 m=1 gcon=1 rf=0 stis=2 dtemp=0 gns=0
    MB2 (VCMFB VREF tb GND) nfet l=40u w=500.0n nf=1 m=1 gcon=1 rf=0 stis=2 dtemp=0 gns=0
    MB1 (VDD ON tb GND) nfet l=40u w=500.0n nf=1 m=1 gcon=1 rf=0 stis=2 dtemp=0 gns=0
    MA2 (VCMFB VREF ta GND) nfet l=40u w=500.0n nf=1 m=1 gcon=1 rf=0 stis=2 dtemp=0 gns=0
    MA1 (VDD OP ta GND) nfet l=40u w=500.0n nf=1 m=1 gcon=1 rf=0 stis=2 dtemp=0 gns=0
    MD (VCMFB VCMFB VDD VDD) pfet l=4u w=2.932u nf=1 m=1 gcon=1 rf=0 dtemp=0
ends ece203_r7a_cmfb_a2

// Project/ece203_r7a_det_tb_a2/schematic
VON (on 0) vsource dc=vcm-vd/2 mag=0 type=dc
VOP (op 0) vsource dc=vcm+vd/2 mag=0 type=dc
VLD (vld 0) vsource dc=vref mag=0 type=dc
VREF (vref 0) vsource dc=vref mag=0 type=dc
VDDC (vddc 0) vsource dc=vdd mag=0 type=dc
VDD (vdd 0) vsource dc=vdd mag=0 type=dc
IB (vdd ib) isource dc=ib3 mag=0 type=dc
MREF (ib ib 0 0) nfet l=4u w=2u nf=1 m=1 gcon=1 rf=0 stis=2 dtemp=0 gns=0
M4R (vld vg vdd vdd) pfet l=4u w=2u nf=1 m=1 gcon=1 rf=0 dtemp=0
M3R (vld vg vdd vdd) pfet l=4u w=2u nf=1 m=1 gcon=1 rf=0 dtemp=0
XC (0 ib on op vg vddc vref) ece203_r7a_cmfb_a2
simulatorOptions options reltol=1e-5 iabstol=1e-17 temp=27 tnom=25 gmin=1e-18
dc dc param=vd start=-0.2 stop=0.2 step=0.002
