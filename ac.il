;; ac.il -- AutoCircuit entry point. Loads the PDK config, the helper libraries
;; and every circuit script.
;;
;; In the CIW, one line does everything for a job (pull, reload, run, report):
;;   load("~/AutoCircuit/ac.il") acGo("p1a")
;; Just reload the latest scripts:
;;   acReload()
;; Over SSH (no GUI):
;;   ~/AutoCircuit/run.sh p1a

acRoot = or(getShellEnvVar("AC_ROOT") strcat(getShellEnvVar("HOME") "/AutoCircuit"))

;; order matters: PDK config, then libraries, then circuits
acFiles = '("pdk_cmrf7sf.il" "lib_draw.il" "lib_sim.il" "lib_ade.il"
            "cs_amp.il" "cs_wsweep.il"
            "hw1_p1a.il" "rf_cap.il" "rf_ind.il" "gmid.il" "wsub.il" "hw1_setup.il" "sps.il" "spsg.il" "hw2_setup.il" "hw3_setup.il"
            "ece203_lib.il" "ece203_hp.il" "ece203_ideal.il" "ece203_ota.il" "ece203_noise_scan.il" "ece203_load.il" "ece203_ss.il" "ece203_ss_lscan.il" "ece203_ss_pr.il" "ece203_ss_otacmp.il" "ece203_ss_chop.il" "ece203_ss_chop_noise.il" "ece203_r4.il" "ece203_r5.il" "ece203_r6a.il" "ece203_r6b.il" "ece203_r5n.il" "ece203_r5nl.il" "ece203_r5nn.il" "ece203_r5nf.il" "ece203_r6c.il" "ece203_r6d.il" "ece203_r6dr.il" "ece203_r7a.il" "ece203_r7b.il" "ece203_r7c.il" "ece203_r7d.il" "ece203_r7e.il" "ece203_r7f.il" "ece203_r8_noise.il" "ece203_r8b.il" "ece203_r8c.il" "ece203_r8d.il" "ece203_r8e.il" "ece203_f2i.il" "ece203_f2v.il" "ece203_f2s.il")

;; steps per job for acGo, run in order; each step is a function of no arguments
acJobs = list(nil
  'p1a  '(p1aRun p1aAde)
  'capc '(capcRun)
  'indb '(indbRun)
  'gmid '(gmidRun)
  'wsub '(wsubRun)
  'hw1 '(hw1Setup)
  'hw1check '(hw1Check)
  'p1c '(hw1P1cTest)
  'p1cp '(hw1P1cTestP)
  'spsscan '(spsScan)
  'sps '(spsRun)
  'spsade '(spsAde)
  'spsg '(spsgRun)
  'spsgade '(spsgAde)
  'spsgsum '(spsgSummary)
  'hw2setup '(hw2Setup)
  'hw2check '(hw2Check)
  'hw2ftsweep '(hw2FtSweep)
  'hw3build '(hw3BuildAll)
  'hw3ade '(hw3Ade)
  'hw3check '(hw3Check)
  'ece203_hp '(hpAll)
  'ece203_hpfb '(hpFbAll)
  'ece203_ideal '(idealAll)
  'ece203_a3 '(a3All)
  'ece203_a12bias '(a12BiasAll)
  'ece203_a12 '(a12All)
  'ece203_probe '(ece203ProbeSymbols)
  'ece203_noise_probe '(nsProbe)
  'ece203_noise_scan '(nsAll)
  'ece203_noise_rebias '(nsRebiasAll)
  'ece203_load_probe '(ldProbeJob)
  'ece203_load_chain '(ldChainJob)
  'ece203_load_isolate '(ldIsolateJob)
  'ece203_load_sweep '(ldSweepJob)
  'ece203_ss_run '(ssRunJob)
  'ece203_ss_ade '(ssAde)
  'ece203_ss_lscan '(lsRunJob)
  'ece203_ss_lscan_ade '(lsAde)
  'ece203_ss_pr_a '(prStageAJob)
  'ece203_ss_pr_a2 '(prStageA2Job)
  'ece203_ss_pr_b '(prStageBJob)
  'ece203_ss_pr_ade '(prAde)
  'ece203_ss_ota_cmp '(ocRunJob)
  'ece203_ss_ota_cmp_ade '(ocAde)
  'ece203_ss_chop_probe '(chProbe)
  'ece203_ss_chop '(chRunJob)
  'ece203_ss_chop_ade '(chAde)
  'ece203_ss_chop_noise '(cnRunJob)
  'ece203_r4_a '(r4StageA)
  'ece203_r4_b '(r4StageB)
  'ece203_r4_c1 '(r4C1)
  'ece203_r4_c2 '(r4C2)
  'ece203_r4_c3 '(r4C3)
  'ece203_r4_c4 '(r4C4)
  'ece203_r4_c4read '(r4C4Read)
  'ece203_r4_d '(r4StageD)
  'ece203_r4_dpss '(r4DPssRead)
  'ece203_r4_ade '(r4Ade)
  'ece203_r5_a '(r5StageA)
  'ece203_r5_b '(r5StageB)
  'ece203_r5_d '(r5StageD)
  'ece203_r5_dsb '(r5StageDsb)
  'ece203_r5_e_cd '(r5StageEcd)
  'ece203_r5_e_cs '(r5StageEcs)
  'ece203_r5_ade '(r5Ade)
  'ece203_r6a_a '(r6StageA)
  'ece203_r6a_b '(r6StageB)
  'ece203_r6a_c '(r6StageC)
  'ece203_r6a_d '(r6StageD)
  'ece203_r6a_d2 '(r6StageD2)
  'ece203_r6a_ade '(r6Ade)
  'ece203_r6b_unit '(r6bStageUnit)
  'ece203_r6b_sys '(r6bStageSys)
  'ece203_r6b_pss '(r6bStagePss)
  'ece203_r6b_ade '(r6bAde)
  'ece203_r5n_a '(r5nStageA)
  'ece203_r5n_b '(r5nStageB)
  'ece203_r5n_pilot '(r5nStagePilot)
  'ece203_r5n_pilot2 '(r5nStagePilot2)
  'ece203_r5n_c '(r5nStageC)
  'ece203_r5n_ade '(r5nAde)
  'ece203_r5nl_a '(r5nlStageA)
  'ece203_r5nl_c '(r5nlStageC)
  'ece203_r5nl_ade '(r5nlAde)
  'ece203_r5nn_a '(r5nnStageA)
  'ece203_r5nn_b '(r5nnStageB)
  'ece203_r5nn_ade '(r5nnAde)
  'ece203_r5nf_a '(r5nfStageA)
  'ece203_r5nf_a3 '(r5nfStageA3)
  'ece203_r5nf_b '(r5nfStageB)
  'ece203_r5nf_ade '(r5nfAde)
  'ece203_r6c_a '(r6cStageA)
  'ece203_r6c_b '(r6cStageB)
  'ece203_r6c_c '(r6cStageC)
  'ece203_r6c_ade '(r6cAde)
  'ece203_r6d_build_ref '(r6dBuildRef)
  'ece203_r6d_build_direct '(r6dBuildDirect)
  'ece203_r6d_build_buf '(r6dBuildBuf)
  'ece203_r6d_a '(r6dStageA)
  'ece203_r6d_b '(r6dStageB)
  'ece203_r6d_ade '(r6dAde)
  'ece203_r6dr_probe '(r6drProbe)
  'ece203_r6dr_short '(r6drShort)
  'ece203_r6dr_full '(r6drFull)
  'ece203_r7a_base '(r7aBaseline)
  'ece203_r7a_build_det '(r7aBuildDet)
  'ece203_r7a_det '(r7aDet)
  'ece203_r7a_build_sys '(r7aBuildSys)
  'ece203_r7a_sys_a '(r7aSysA)
  'ece203_r7a_sys_b '(r7aSysB)
  'ece203_r7a_ade '(r7aAde)
  'ece203_r7b_cap '(r7bCap)
  'ece203_r7b_build '(r7bBuild)
  'ece203_r7b_smoke '(r7bSmoke)
  'ece203_r7b_tran '(r7bTran)
  'ece203_r7c_a '(r7cStageA)
  'ece203_r7c_build '(r7cBuild)
  'ece203_r7c_b '(r7cStageB)
  'ece203_r7c_bnum '(r7cStageBnum)
  'ece203_r7c_c '(r7cStageC)
  'ece203_r7c_ade '(r7cAde)
  'ece203_r7d_build '(r7dBuild)
  'ece203_r7d_a '(r7dStageA)
  'ece203_r7d_b '(r7dStageB)
  'ece203_r7d_c '(r7dStageC)
  'ece203_r7d_ade '(r7dAde)
  'ece203_r7e_build '(r7eBuild)
  'ece203_r7e_a '(r7eStageA)
  'ece203_r7e_b '(r7eStageB)
  'ece203_r7e_c '(r7eStageC)
  'ece203_r7e_ade '(r7eAde)
  'ece203_r7f_build '(r7fBuild)
  'ece203_r7f_a '(r7fStatic)
  'ece203_r7f_c '(r7fTran)
  'ece203_r7f_ade '(r7fAde)
  'ece203_r8_a '(r8StageA)
  'ece203_r8_t0 '(r8Tran0)
  'ece203_r8_pss '(r8Pss)
  'ece203_r8_pac '(r8Pac)
  'ece203_r8_pn '(r8Pn)
  'ece203_r8b_build '(r8bBuild)
  'ece203_r8b_a '(r8bA)
  'ece203_r8b_t0 '(r8bT0)
  'ece203_r8b_pss '(r8bPss)
  'ece203_r8b_pac '(r8bPac)
  'ece203_r8b_pn '(r8bPn)
  'ece203_r8c_a1off '(r8cA1off)
  'ece203_r8c_a1pac '(r8cA1pac)
  'ece203_r8c_build '(r8cBuild)
  'ece203_r8c_b0 '(r8cB0)
  'ece203_r8c_bpss '(r8cBpss)
  'ece203_r8c_bpac '(r8cBpac)
  'ece203_r8d_unit '(r8dUnit)
  'ece203_r8d_build '(r8dBuild)
  'ece203_r8d_off '(r8dOff)
  'ece203_r8d_pss '(r8dPss)
  'ece203_r8d_pac '(r8dPac)
  'ece203_r8e_build '(r8eBuild)
  'ece203_r8e_static '(r8eStatic)
  'ece203_r8e_pss '(r8ePss)
  'ece203_r8e_pac '(r8ePac)
  'ece203_r8e_pnoise '(r8ePn)
  'ece203_r8e_tran '(r8eTran)
  'ece203_f2i_probe '(f2iProbe)
  'ece203_f2i_build '(f2iJobBuild)
  'ece203_f2i_ac '(f2iJobAc)
  'ece203_f2i_tran '(f2iJobTran)
  'ece203_f2v_ocean '(f2vOcean)
  'ece203_f2s_build '(f2sJobBuild)
  'ece203_f2s_winner_ac '(f2sJobWinnerAc)
  'ece203_f2s_tran '(f2sJobTran)
  'ece203_f2s_ade '(f2sAde)
)

;; ---------- reporting ----------
;; acSay prints to the CIW and, during acGo, also to ~/AutoCircuit_results/ciw_<job>.txt
;; so the report can be read (and copied) over SSH.
unless( boundp('acLogPort) acLogPort = nil )

procedure( acSay(fmt @rest args)
  let( (msg)
    ;; lsprintf is the lambda form of sprintf: apply() must not re-evaluate the args
    msg = if( isCallable('lsprintf)
            then apply('lsprintf cons(fmt args))
            else apply('sprintf append(list(nil fmt) mapcar(lambda((a) list('quote a)) args))))
    printf("AC> %s" msg)
    when( acLogPort
      fprintf(acLogPort "%s" msg)
      drain(acLogPort))
    msg
  )
)

;; ---------- loading ----------
procedure( acLoadAll()
  foreach(f acFiles
    load(strcat(acRoot "/" f)))
  printf("AutoCircuit loaded (%d files) from %s\n" length(acFiles) acRoot)
  t
)

procedure( acReload()
  if( sh(strcat("cd " acRoot " && git pull -q")) then
    printf("git pull ok\n")
  else
    warn("git pull failed -- loading the local copy\n")
  )
  load(strcat(acRoot "/ac.il"))
)

;; ---------- batch (run.sh) ----------
;; run a job function: errors are reported, never left hanging
procedure( acBatch(fn)
  let( (ok)
    ok = errset(funcall(fn) t)
    if( ok then
      printf("AC_BATCH_DONE\n")
    else
      printf("AC_BATCH_FAILED: %L\n" errset.errset)
    )
    ok
  )
)

;; ---------- one-shot runner for the CIW ----------
;; pulls from GitHub, reloads, runs every step of the job and writes the report to
;; ~/AutoCircuit_results/ciw_<job>.txt   (over SSH: cat ~/AutoCircuit_results/ciw_p1a.txt)
procedure( acGo(job)
  let( (steps dir file ok)
    when( stringp(job) job = stringToSymbol(job) )
    sh(strcat("cd " acRoot " && git pull -q"))
    load(strcat(acRoot "/ac.il"))
    steps = get(acJobs job)
    dir = strcat(getShellEnvVar("HOME") "/AutoCircuit_results")
    unless( isDir(dir) createDir(dir) )
    file = strcat(dir "/ciw_" get_pname(job) ".txt")
    when( acLogPort errset(close(acLogPort) nil) )   ; left open by an interrupted run
    acLogPort = outfile(file "w")
    acSay("acGo %L  steps %L\n" job steps)
    unless( steps acSay("unknown job %L -- known jobs: %L\n" job acJobs) )
    foreach(st steps
      acSay("---- %L ----\n" st)
      ok = errset(funcall(st) t)
      acSay("---- %L %s\n" st if( ok "done" sprintf(nil "FAILED: %L" errset.errset))))
    acSay("acGo finished\n")
    close(acLogPort)
    acLogPort = nil
    printf("Report: %s\n" file)
    t
  )
)

acLoadAll()
