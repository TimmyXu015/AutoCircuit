;; ECE203 F2 interference task: frozen early non-chopped F2 (Project/ece203_r5nf_tb_f2, OTA ece203_r5nf_ota_f2) under
;; 0 / 100 nA / 1 uA 60 Hz body interference, using the professor's ECG_tb scenario.
;; Task: docs/ECE203_F2_1uA_interference_gain_task.md.  Library rule (user, 2026-11-25): nothing is ever written into any 203ECG*
;; library (read + copy-from only); all new cells live in Project.
;; Step 1 (this file so far): read-only probe of the libraries, the instructor ECG_tb and the F2 fixture. No cell is created or edited.

f2iDir = strcat(getShellEnvVar("HOME") "/AutoCircuit_results/ece203_f2i")
procedure( f2iMk() unless( isDir(f2iDir) sh(sprintf(nil "mkdir -p %s" f2iDir))) )
procedure( f2iP(port fmt @rest a) apply('fprintf cons(port cons(fmt a))) )

;; read-only dump of one schematic (instances, master, terminals -> nets, user/CDF properties, pins)
procedure( f2iDumpSch(port lib cell)
  let( (cv)
    cv = dbOpenCellViewByType(lib cell "schematic" nil "r")
    if( !cv then f2iP(port "  (no schematic view)\n")
    else
      f2iP(port "  views: %L\n" ddGetObj(lib cell)~>views~>name)
      f2iP(port "  terminals (pins): %L\n" mapcar(lambda((tm) list(tm~>name tm~>direction)) cv~>terminals))
      f2iP(port "  nets: %L\n" sort(cv~>nets~>name 'alphalessp))
      foreach(inst cv~>instances
        f2iP(port "  INST %s  %s/%s/%s\n" inst~>name inst~>libName inst~>cellName inst~>viewName)
        foreach(it inst~>instTerms f2iP(port "     term %s -> %s\n" it~>name it~>net~>name))
        foreach(p inst~>prop f2iP(port "     prop %s = %L\n" p~>name p~>value)))
      dbClose(cv))
    t
  )
)
procedure( f2iProbe()
  let( (port hits libs)
    f2iMk()
    port = outfile(strcat(f2iDir "/probe_libraries.txt") "w")
    libs = sort(ddGetLibList()~>name 'alphalessp)
    f2iP(port "libraries (%d): %L\n\n" length(libs) libs)
    ;; every cell whose name looks like an ECG testbench, in every library
    foreach(lib ddGetLibList()
      foreach(c lib~>cells
        when( rexMatchp("[Ee][Cc][Gg].*[Tt][Bb]\\|[Tt][Bb].*[Ee][Cc][Gg]" c~>name)
          hits = cons(list(lib~>name c~>name c~>views~>name) hits))))
    f2iP(port "ECG testbench-like cells: \n")
    foreach(h reverse(hits) f2iP(port "  %s / %s  views %L\n" car(h) cadr(h) caddr(h)))
    ;; cells of non-Project, non-PDK libraries (to see where course material lives)
    foreach(lib ddGetLibList()
      unless( member(lib~>name '("Project" "analogLib" "basic" "cdsDefTechLib" "functional" "sbaLib" "ahdlLib" "rfLib" "US_8ths" "cmrf7sf" "rfExamples" "bicmos7wl"))
        f2iP(port "\nLIB %s (%s): %d cells: %L\n" lib~>name lib~>readPath length(lib~>cells) sort(lib~>cells~>name 'alphalessp))))
    close(port)
    ;; read-only schematic dumps of every hit + the frozen F2 fixture
    port = outfile(strcat(f2iDir "/probe_schematics.txt") "w")
    foreach(h reverse(hits)
      f2iP(port "\n==== %s / %s (read-only)\n" car(h) cadr(h))
      car(errset(f2iDumpSch(port car(h) cadr(h)) t)))
    ;; explicit targets (found by the first probe: the instructor ECG_tb is a LIBRARY ECG_tb with cell ECG_tb, under public/)
    foreach(lc '(("ECG_tb" "ECG_tb") ("203ECG_CCF_TwoStage" "ECG_tb_DRL") ("203ECG_CCF_TwoStage" "ECG_tb_NoDRL"))
      f2iP(port "\n==== %s / %s (read-only; path %s)\n" car(lc) cadr(lc) ddGetObj(car(lc))~>readPath)
      car(errset(f2iDumpSch(port car(lc) cadr(lc)) t)))
    f2iP(port "\n==== Project / ece203_r5nf_tb_f2 (frozen F2 fixture, read-only)\n")
    car(errset(f2iDumpSch(port "Project" "ece203_r5nf_tb_f2") t))
    close(port)
    acSay("f2i probe: %d ECG-tb-like cells: %L\n" length(hits) reverse(hits))
    t
  )
)

;; =====================================================================================================================
;; Step 2: isolated copy of the instructor ECG_tb in Project + the frozen F2 system, and the measurements.
;; Source  : library ECG_tb (public/ECG_tb), cell ECG_tb, schematic -- opened read-only, copied FROM (never written).
;; Copy    : Project/ece203_f2_1ua_prof_tb. In the copy, only the two stimulus instances are re-parameterised:
;;           V0 (vsin, ECG source)  va vecg, freq fecg, sinephase phecg, acm aecg    (instructor: 1m, 10, -, 1m)
;;           I2 (isin, body current) ia iint, freq fint, sinephase phint, acm aint   (instructor: 1u, 60, -, 1u)
;;           Everything else of the instructor schematic (R1..R9, C0..C3, gnd) is kept as copied.
;; DUT     : the frozen F2 system = r5SpecsE("cs") with XA -> ece203_r5nf_ota_f2 (exactly how ece203_r5nf_tb_f2 was built),
;;           minus the archived F2 fixture (CBODY IINT IINTT VSP VSN RSP REP CEP RSN REN CEN RSR RER CER), with nets
;;           inpr -> vRight, innr -> vLeft (so the 0 V meters VPP / VPN still sit between electrode and amplifier) and
;;           rl0b -> vRL (DRL drive 1 MOhm RDRR -> IPRD -> instructor right-leg electrode).
;;           vRight -> F2 inp (the Vref-side input, = archived VSP side), vLeft -> F2 inn (feedback side), as in the user's
;;           own 203ECG_CCF_TwoStage/ECG_tb_DRL (read-only reference).
;; Design variables = r4Vars + r5nOver(4e-6) (= the F2 signoff set) + the stimulus variables below.
f2iCell = "ece203_f2_1ua_prof_tb"
f2iF2Cell = "ece203_r5nf_tb_f2"
f2iF2Ota = "ece203_r5nf_ota_f2"
f2iFixture = '("CBODY" "IINT" "IINTT" "VSP" "VSN" "RSP" "REP" "CEP" "RSN" "REN" "CEN" "RSR" "RER" "CER")
f2iRename = '(("inpr" "vRight") ("innr" "vLeft") ("rl0b" "vRL"))
f2iTmp = "/tmp/lix015_f2i"
procedure( f2iStim(@optional over)
  append(list(list("vecg" 1e-3) list("fecg" 10.0) list("phecg" 0.0) list("aecg" 0.0)
              list("iint" 0.0) list("fint" 60.0) list("phint" 0.0) list("aint" 0.0) list("dcc" 0.0)) over)
)
;; f2iExtraVars (default nil): extra design-variable overrides appended last (used by F2S for the winner's cc / cfb / prw)
unless( boundp('f2iExtraVars) f2iExtraVars = nil)
procedure( f2iVars(over) append(append(append(r5nOver(4e-6) f2iStim()) over) f2iExtraVars) )
procedure( f2iMapNet(n) let( (m) m = assoc(n f2iRename) if( m cadr(m) n) ) )
procedure( f2iDutSpecs()
  let( (all keep gone)
    all = mapcar(lambda((e) if( caddr(e) == "XA" cons(car(e) cons(f2iF2Ota cddr(e))) e)) r5SpecsE("cs"))
    keep = setof(e all !member(caddr(e) f2iFixture))
    gone = setof(e all member(caddr(e) f2iFixture))
    unless( length(gone) == length(f2iFixture) error("fixture removal mismatch: %L" mapcar('caddr gone)))
    mapcar(lambda((e) list(nth(0 e) nth(1 e) nth(2 e) nth(3 e)
                           mapcar(lambda((c) list(car(c) f2iMapNet(cadr(c)))) nth(4 e))))
           keep)
  )
)
procedure( f2iBuild()
  let( (src dst cv i v ok)
    ece203LibInfo()
    unless( ddGetObj("ECG_tb" "ECG_tb") error("instructor library/cell ECG_tb/ECG_tb not found"))
    when( rexMatchp("203ECG" ddGetObj("ECG_tb")~>readPath) error("ECG_tb resolves into a 203ECG* path - refusing"))
    foreach(x list(f2iF2Cell f2iF2Ota "ece203_ss_pr_cell" r4Cells->drl) unless( ddGetObj(ece203Lib x) error("missing Project/%s" x)))
    when( ddGetObj(ece203Lib f2iCell) error("Project/%s already exists" f2iCell))
    src = dbOpenCellViewByType("ECG_tb" "ECG_tb" "schematic" nil "r")
    unless( src error("cannot open ECG_tb/ECG_tb/schematic read-only"))
    dst = dbCopyCellView(src ece203Lib f2iCell "schematic")
    dbClose(src)
    unless( dst error("dbCopyCellView into Project failed"))
    dbSave(dst) dbClose(dst)
    cv = dbOpenCellViewByType(ece203Lib f2iCell "schematic" nil "a")
    unless( cv error("cannot reopen the copy for edit"))
    v = dbFindAnyInstByName(cv "V0") i = dbFindAnyInstByName(cv "I2")
    unless( and(v i v~>cellName == "vsin" i~>cellName == "isin") error("V0 vsin / I2 isin not found in the copy"))
    foreach(p '(("va" "vecg") ("freq" "fecg") ("sinephase" "phecg") ("acm" "aecg"))
      unless( acSetParam(v car(p) cadr(p)) error("V0 has no CDF parameter %s" car(p))))
    foreach(p '(("ia" "iint") ("freq" "fint") ("sinephase" "phint") ("acm" "aint"))
      unless( acSetParam(i car(p) cadr(p)) error("I2 has no CDF parameter %s" car(p))))
    ;; F2 system placed far below the instructor drawing (grid start 300 = 50 rows down); connection by net labels only
    ece203Place(cv f2iDutSpecs() 300)
    ece203Finish(cv ece203Lib f2iCell)
    acSay("f2i: built Project/%s = copy of ECG_tb/ECG_tb + F2 (%d instances added); V0/I2 re-parameterised\n" f2iCell length(f2iDutSpecs()))
    t
  )
)
;; net name of an instance terminal in a schematic (read-only)
procedure( f2iNet(cell inst term)
  let( (cv in n)
    cv = dbOpenCellViewByType(ece203Lib cell "schematic" nil "r")
    in = and(cv dbFindAnyInstByName(cv inst))
    n = and(in car(setof(it in~>instTerms it~>name == term))~>net~>name)
    when( cv dbClose(cv))
    n
  )
)
procedure( f2iNets()
  list(nil 'srcp f2iNet(f2iCell "V0" "PLUS") 'srcn f2iNet(f2iCell "V0" "MINUS") 'body f2iNet(f2iCell "C0" "PLUS"))
)
procedure( f2iKv(file r)
  let( (port)
    port = outfile(file "w") fprintf(port "key,value\n")
    foreach(k cdr(r) when( symbolp(k) let( (x) x = get(r k) fprintf(port "%s,%s\n" k cond( (numberp(x) sprintf(nil "%.9g" float(x))) (stringp(x) x) (t "n/a"))))))
    close(port)
  )
)
f2iDcNodes = '("out" "o" "oa" "oa1" "p" "n" "inp" "inn" "vRight" "vLeft" "vRL" "cm" "drlr" "drli" "rl0" "vref" "vcas" "ib" "ibd" "pref")
;; AC: kind 'dm (ECG source AC 1, interference AC 0) or 'int (ECG 0, interference AC 1 A); on the copy or (ref) on the F2 cell
procedure( f2iAc(tag kind ref)
  let( (r cell nets vin vpost out h hp hb port body hi)
    f2iMk()
    cell = if( ref f2iF2Cell f2iCell)
    r = list(nil 'tag tag 'cell cell 'kind kind 'status "ok")
    nets = unless( ref f2iNets())
    ece203Setup(cell strcat("_f2i_" tag))
    r4Tight()
    analysis('dc ?saveOppoint t)
    analysis('ac ?start "1m" ?stop "100k" ?dec "50")
    car(errset(save('i "/VDD/PLUS" "/VDDD/PLUS" "/VPP/PLUS" "/VPN/PLUS" "/IPRD/PLUS") nil))
    r4Set(if( ref
              append(r5nOver(4e-6) list(list("adm" 1.0) list("vcmin" 0.0) list("icm" 0.0) list("itr" 0.0) list("dcc" 0.0)))
              f2iVars(if( kind == 'dm list(list("aecg" 1.0) list("aint" 0.0)) list(list("aecg" 0.0) list("aint" 1.0))))))
    run()
    out = ldAc("out")
    unless( out error("no ac result (%s)" tag))
    vpost = ldAc("inp") - ldAc("inn")
    vin = if( ref ldAc("ep") - ldAc("en") ldAc(nets->srcp) - ldAc(nets->srcn))
    when( kind == 'dm
      h = ldDiv(out vin) hp = ldDiv(out vpost) hb = ldDiv(vpost vin)
      foreach(f '(1.0 10.0 60.0 100.0 250.0)
        putprop(r ldMag(h f) stringToSymbol(sprintf(nil "Hsrc_%g" f)))
        putprop(r ldMag(hp f) stringToSymbol(sprintf(nil "Hpost_%g" f)))
        putprop(r ldMag(hb f) stringToSymbol(sprintf(nil "post_over_src_%g" f))))
      ldWriteCurves(strcat(f2iDir "/" tag "_ac.csv") list(list("Hsrc" h) list("Hpost" hp) list("post_over_src" hb))))
    when( kind == 'int
      body = ldAc(nets->body)
      hi = list(list("out" out) list("body" body) list("vpost" vpost) list("vcm_el" (ldAc("vRight") + ldAc("vLeft")) / 2.0)
                list("drlr" ldAc("drlr")) list("cm" ldAc("cm")))
      foreach(f '(10.0 60.0 100.0)
        putprop(r ldMag(out f) stringToSymbol(sprintf(nil "out_per_A_%g" f)))
        putprop(r ldMag(body f) stringToSymbol(sprintf(nil "body_per_A_%g" f)))
        putprop(r ldMag(ldAc("drlr") f) stringToSymbol(sprintf(nil "drlr_per_A_%g" f))))
      ldWriteCurves(strcat(f2iDir "/" tag "_ac.csv") hi))
    foreach(n append(f2iDcNodes if( ref '("ep" "en" "body") list(nets->srcp nets->srcn nets->body)))
      putprop(r ldDc(n) stringToSymbol(strcat("dc_" n))))
    r->I_VDD = ldIdc("/VDD/PLUS") r->I_VDDD = ldIdc("/VDDD/PLUS")
    r->nets = if( ref "ep/en/inp/inn" sprintf(nil "srcp %s srcn %s body %s" nets->srcp nets->srcn nets->body))
    ece203OpDump(strcat(f2iDir "/" tag "_dcop.csv") append(append(r4OpInsts r4DrlInsts) '("X2.MCS" "X2.MCL" "MP0" "MP1" "MP2")))
    sh(sprintf(nil "cp %s/simulation/%s/spectre/schematic/netlist/input.scs %s/%s_netlist.scs" getShellEnvVar("HOME") cell f2iDir tag))
    f2iKv(strcat(f2iDir "/" tag ".csv") r)
    acSay("f2i AC %s (%s, %s): src %s | Hsrc 10/60/100 %s %s %s | Hpost 10/60/100 %s %s %s | out/A 60 %s body/A 60 %s drl/A 60 %s | DC out %s oa %s oa1 %s p %s n %s cm %s drlr %s vref %s | I %s\n"
          tag cell kind r->nets r8Num(r->Hsrc_10) r8Num(r->Hsrc_60) r8Num(r->Hsrc_100) r8Num(r->Hpost_10) r8Num(r->Hpost_60) r8Num(r->Hpost_100)
          r8Num(r->out_per_A_60) r8Num(r->body_per_A_60) r8Num(r->drlr_per_A_60)
          r8Num(r->dc_out) r8Num(r->dc_oa) r8Num(r->dc_oa1) r8Num(r->dc_p) r8Num(r->dc_n) r8Num(r->dc_cm) r8Num(r->dc_drlr) r8Num(r->dc_vref) r8Num(r->I_VDD))
    r
  )
)
;; transient on the copy: stimulus via design variables, selected node set saved, full-resolution CSV gz + sha256
procedure( f2iTran(tag over stop maxstep)
  let( (nets sim psf names w h ok r wlog)
    f2iMk() sh(sprintf(nil "mkdir -p %s/out" f2iTmp))
    nets = f2iNets()
    sim = sprintf(nil "%s/sim_%s" f2iTmp tag) psf = strcat(sim "/psf") wlog = strcat(f2iTmp "/out/watchdog.log")
    sh(sprintf(nil "rm -rf %s" sim))
    r = list(nil 'tag tag 'status "ok" 'stop stop 'maxstep maxstep)
    ok = errset(
      progn(
        ece203Setup(f2iCell strcat("_f2i_" tag))
        resultsDir(sim)
        r4Tight()
        analysis('tran ?stop stop ?maxstep maxstep)
        car(errset(saveOption('save "selected") nil))
        car(errset(apply('save cons('v mapcar(lambda((n) strcat("/" n))
             append(list(nets->srcp nets->srcn nets->body) '("vRight" "vLeft" "vRL" "inp" "inn" "p" "n" "o" "oa" "oa1" "out" "cm" "drlr" "rl0" "vref"))))) nil))
        car(errset(save('i "/IPRD/PLUS" "/VDD/PLUS") nil))
        r4Set(f2iVars(over))
        sh(sprintf(nil "nohup bash %s/tools/f2i_watchdog.sh %s %s 900 %s > /dev/null 2>&1 &" acRoot tag psf wlog))
        run()
        when( isFile(strcat(sim "/WATCHDOG_STALL")) error("stopped by the watchdog"))
        names = "t_s" w = nil
        foreach(n append(list(list("src_p" nets->srcp) list("src_n" nets->srcn) list("body" nets->body))
                         mapcar(lambda((x) list(x x)) '("vRight" "vLeft" "vRL" "inp" "inn" "p" "n" "o" "oa" "oa1" "out" "cm" "drlr" "rl0" "vref")))
          when( setq(h car(errset(v(strcat("/" cadr(n)) ?result "tran") nil))) w = append(w list(h)) names = strcat(names "," car(n) "_V")))
        foreach(n '(("I_IPRD" "/IPRD/PLUS") ("I_VDD" "/VDD/PLUS"))
          when( setq(h car(errset(i(cadr(n) ?result "tran") nil))) w = append(w list(h)) names = strcat(names "," car(n) "_A")))
        r->t_end = car(errset(xmax(xval(car(w))) nil))   ;; last time point
        ;; Output (plan update 2): SKILL CSV writing of every Spectre point (60-125 k rows) took 5-15 min per case. Default now:
        ;;  - exact full-resolution min / max of every saved signal over each of the last two 1 s windows (kv CSV),
        ;;  - <tag>_tran.csv: the last 2 s resampled on a uniform 100 us grid (linear interpolation of the <= 50 us Spectre steps),
        ;;  - <tag>_tran1ms.csv.gz: the whole run resampled at 1 ms (DC-drift trend).
        ;; AC_F2I_FULL=1 restores the old full-resolution CSV of the whole run (used for T0_3s and I1u_3s).
        let( (st)
          st = atof(stop)
          if( getShellEnvVar("AC_F2I_FULL")
            then spsWriteWaves(sprintf(nil "%s/%s_tran.csv" f2iDir tag) names w)
            else
              foreach(win list(list(st - 2.0 st - 1.0) list(st - 1.0 st))
                foreach(nw mapcar('list parseString(names ",") cons(nil w))
                  when( cadr(nw)
                    putprop(r car(errset(ymin(clip(cadr(nw) car(win) cadr(win))) nil)) stringToSymbol(sprintf(nil "min_%s_w%g" car(nw) cadr(win))))
                    putprop(r car(errset(ymax(clip(cadr(nw) car(win) cadr(win))) nil)) stringToSymbol(sprintf(nil "max_%s_w%g" car(nw) cadr(win)))))))
              spsWriteWaves(sprintf(nil "%s/%s_tran.csv" f2iDir tag) names mapcar(lambda((x) sample(x st - 2.0 st "linear" 1e-4)) w))
              spsWriteWaves(sprintf(nil "%s/%s_tran1ms.csv" f2iDir tag) names mapcar(lambda((x) sample(x 0 st "linear" 1e-3)) w))
              sh(sprintf(nil "cd %s && gzip -f %s_tran1ms.csv" f2iDir tag))
              r->csv_grid = "last 2 s at 100 us + 1 ms trend"))
        sh(sprintf(nil "cd %s && sha256sum %s_tran.csv > %s_tran.csv.sha256 && gzip -f %s_tran.csv" f2iDir tag tag tag))
        t)
      t)
    unless( ok r->status = "failed" r->reason = sprintf(nil "%L" errset.errset))
    foreach(o over putprop(r cadr(o) stringToSymbol(car(o))))
    sh(sprintf(nil "cp %s/simulation/%s/spectre/schematic/netlist/input.scs %s/%s_netlist.scs" getShellEnvVar("HOME") f2iCell f2iDir tag))
    sh(sprintf(nil "cp %s/spectre.out %s/%s_spectre.out 2>/dev/null; gzip -f %s/%s_spectre.out; du -sh %s > %s/%s_psf_size.txt; rm -rf %s" psf f2iDir tag f2iDir tag psf f2iDir tag sim))
    f2iKv(strcat(f2iDir "/" tag ".csv") r)
    acSay("f2i TRAN %s: %s %s | t_end %s\n" tag r->status or(r->reason "") r8Num(r->t_end))
    r
  )
)
;; ---------------- jobs ----------------
procedure( f2iJobBuild() f2iBuild() )
;; Test 1: archived-fixture reference + instructor-TB nominal DC/AC (dm) + interference AC (diagnostic)
procedure( f2iJobAc()
  let( (od)
    od = r4Dir r4Dir = f2iDir
    f2iAc("A_ref_f2fixture_dm" 'dm t)
    r4Dir = od
    f2iAc("A_prof_dm" 'dm nil)
    f2iAc("A_prof_int" 'int nil)
    t
  )
)
;; transient cases, selected by AC_F2I_CASES (space-separated names from f2iTranCases); stop / maxstep from env (default 3 s / 50 us)
f2iTranCases = list(nil
  'T0    '(("vecg" 1e-3) ("iint" 0.0))
  'T100n '(("vecg" 1e-3) ("iint" 100e-9))
  'T1u   '(("vecg" 1e-3) ("iint" 1e-6))
  'I100n '(("vecg" 0.0)  ("iint" 100e-9))
  'I1u   '(("vecg" 0.0)  ("iint" 1e-6))
  'T0_dcc1  '(("vecg" 1e-3) ("iint" 0.0) ("dcc" 0.01))
  'T1u_dcc1 '(("vecg" 1e-3) ("iint" 1e-6) ("dcc" 0.01))
  'I1u_dcc1 '(("vecg" 0.0)  ("iint" 1e-6) ("dcc" 0.01))
  'S0      '(("vecg" 1e-3) ("fecg" 60.0) ("iint" 0.0))
  'Si      '(("vecg" 0.0)  ("fecg" 60.0) ("iint" 1e-6))
  'S1u_p0   '(("vecg" 1e-3) ("fecg" 60.0) ("phecg" 0.0)   ("iint" 1e-6))
  'S1u_p90  '(("vecg" 1e-3) ("fecg" 60.0) ("phecg" 90.0)  ("iint" 1e-6))
  'S1u_p180 '(("vecg" 1e-3) ("fecg" 60.0) ("phecg" 180.0) ("iint" 1e-6))
  'S1u_p270 '(("vecg" 1e-3) ("fecg" 60.0) ("phecg" 270.0) ("iint" 1e-6)))
procedure( f2iJobTran()
  let( (names stop ms)
    names = parseString(or(getShellEnvVar("AC_F2I_CASES") "T0") " ")
    stop = or(getShellEnvVar("AC_F2I_STOP") "3") ms = or(getShellEnvVar("AC_F2I_MAXSTEP") "50u")
    foreach(n names
      let( (c)
        c = get(f2iTranCases stringToSymbol(n))
        unless( c error("unknown transient case %s" n))
        f2iTran(sprintf(nil "%s_%ss" n stop) c stop ms)))
    t
  )
)
